addrmap ctrl_rf {
    // Register stride: every register sits at its own 16-byte (128-bit)
    // aligned address, matching accel_top's 128-bit Avalon data bus. A
    // 128-bit master only ever presents word-aligned addresses (byte lanes
    // are picked with byteenable), so registers packed 4 bytes apart could
    // not be addressed individually. Each register's value is in the low
    // bits of its word (byte lanes 0..3). Offsets are pinned with @ below.
    //
    // Control Register (0x00) - single sw-pulsed start bit. The rest of the
    // weight/input control sequencing (weight block prefetch, input preload,
    // compute start) is still TODO - it'll be driven some other way, not
    // more single-pulse CONTROL bits like the ones this replaced.
    reg {
        field {
            singlepulse = true; // Single pulse mode
            reset = 0;
            sw = w;    // Read-write
            hw = r;    // No hardware feedback
        } matmul_start;        // a new matmul is starting: latch WEIGHT_ROWS/
                                // WEIGHT_COLS and reset weight_ctrl's block
                                // position to (0,0)

    } CONTROL @ 0x00;

    // Weight matrix dimensions (0x10/0x20). weight_buffer can hold more than
    // one 32x32 tile's worth of weights; these describe the full extent so
    // future multi-tile loads know how many tiles to prefetch.
    //
    // WEIGHT_ROWS/WEIGHT_COLS name which pe_array axis a dimension loads
    // into, NOT "row/col of the weight matrix as you'd write it on paper":
    //   - WEIGHT_ROWS feeds pe_array's ARRAY_ROWS axis, which pe.v's b_in
    //     cascades down and sums - i.e. WEIGHT_ROWS is the CONTRACTION size.
    //   - WEIGHT_COLS feeds ARRAY_COLS - values here stay separate (one
    //     accumulated result per array column) - i.e. the OUTPUT size.
    // If your weight matrix is conventionally (out_features x in_features),
    // program WEIGHT_ROWS = in_features and WEIGHT_COLS = out_features,
    // regardless of which one is literally "rows" in that convention. See
    // rtl/weight_ctrl.v's header comment for the full reasoning.
    reg {
        field {
            sw = w;
            hw = r;
            reset = 0;
        } value [15:0];   // contraction (reduction) dimension size
    } WEIGHT_ROWS @ 0x10;

    reg {
        field {
            sw = w;
            hw = r;
            reset = 0;
        } value [15:0];   // output dimension size
    } WEIGHT_COLS @ 0x20;

    // Input dimensions (0x30/0x40). No separate row-count register: the
    // valid row range for the block currently in the array is derived by
    // weight_ctrl from WEIGHT_ROWS and the current block position, since
    // weight rows (K) and activation rows share the same array-row extent.
    reg {
        field {
            sw = w;
            hw = r;
            reset = 0;
        } value [9:0];    // max input_buffer read address (input_dispatch i_max_addr)
    } INPUT_MAX_ADDR @ 0x30;

    reg {
        field {
            sw = w;
            hw = r;
            reset = 0;
        } value [15:0];   // number of columns of the input (activation) matrix
    } INPUT_COLS @ 0x40;

    // Status Register (0x50)
    reg {
        field {
            sw = r;
            hw = w;
            reset = 0;
        } busy;               // compute running (weights loading, streaming, or draining)

        field {
            sw = r;
            hw = w;
            rclr = true;
        } done;               // whole matmul finished: all blocks committed and drained

    } STATUS @ 0x50;

    // Output rescale factor (0x60). Q0.16 fixed point: unsigned, 0 integer
    // bits + 16 fractional bits, representable range [0, 1) - value/65536
    // is the actual scale. Meant to rescale pe_array's 32-bit accumulator
    // (see pe.v's ACC_WIDTH) back down to int8 under the quantization
    // scheme this array targets; not yet consumed downstream of
    // output_loader (see rtl/accel_top.sv).
    reg {
        field {
            sw = w;
            hw = r;
            reset = 0;
        } value [15:0];
    } OUTPUT_SCALE @ 0x60;

    // Output tile placement (0x70). The output buffer holds one int8 canvas
    // (width: CANVAS_WIDTH); the internal psum buffer holds only the current
    // tile's raw 32-bit sums (see ACT_CFG), up to 128x128. This
    // matmul's WEIGHT_ROWS x INPUT_COLS result lands with its top-left
    // corner at canvas row tile_r*TILE_ROWS, column tile_c*TILE_COLS (see
    // those registers - 0 there means this matmul's own WEIGHT_ROWS /
    // INPUT_COLS). The first row, tile_r*TILE_ROWS, must be a multiple of
    // 16 (output bank boundary); the first column can be anything.
    // use_prev_out: the first contraction block accumulates onto the canvas
    // instead of overwriting it, to split a long contraction across
    // matmuls (the format it reads is ACT_CFG.prev_int8). Continuing raw
    // sums needs the same tile as the out_raw matmul before it, with no
    // other matmul that keeps raw sums in between. Latched at
    // matmul_start. See rtl/accel_top.sv's TILE_CFG latch.
    reg {
        field {
            sw = w;
            hw = r;
            reset = 0;
        } tile_r [14:0];

        field {
            sw = w;
            hw = r;
            reset = 0;
        } tile_c [29:15];

        field {
            sw = w;
            hw = r;
            reset = 0;
        } use_prev_out;
    } TILE_CFG @ 0x70;

    // Output canvas width (0x80), in elements: the whole result's column
    // count when it is built from tiles. Sets the canvas row pitch - rows of
    // the int8 output canvas padded to a 16-byte word - for both the result
    // writes and the host read remap; latched at matmul_start. 0 = use
    // INPUT_COLS, for one untiled matmul. Keep it the same for every tile of
    // one result.
    reg {
        field {
            sw = w;
            hw = r;
            reset = 0;
        } value [15:0];
    } CANVAS_WIDTH @ 0x80;

    // Output activation / format (0x90), latched at matmul_start. Raw 32-bit
    // sums live in the internal psum buffer between contraction blocks; the
    // finished int8 result goes to the output buffer, one byte per element
    // at its canvas position.
    //   bias_en:   add the int32 bias of the element's canvas row (bias
    //              buffer, entry = canvas row mod 256, accumulator units
    //              i.e. scale input_scale*weight_scale) to the 32-bit sum
    //              before the OUTPUT_SCALE rescale.
    //   gelu_en:   pass the rescaled int8 through the GELU lookup table.
    //   prev_int8: with TILE_CFG.use_prev_out, add onto the int8 result
    //              already in the output buffer (rather than continuing raw
    //              sums): this matmul's raw sums start fresh, and the
    //              previous int8 is added to the rescaled value (saturating,
    //              before GELU). Any number of contraction blocks.
    //   out_raw:   keep the raw 32-bit sums in the psum buffer after the
    //              last contraction block (no bias, rescale, GELU, and no
    //              int8 result), for a later use_prev_out matmul on the
    //              same tile to continue (the psum buffer holds one tile).
    // bias_en/gelu_en only act on an int8 result, never with out_raw.
    reg {
        field {
            sw = w;
            hw = r;
            reset = 0;
        } bias_en;

        field {
            sw = w;
            hw = r;
            reset = 0;
        } gelu_en;

        field {
            sw = w;
            hw = r;
            reset = 0;
        } prev_int8;

        field {
            sw = w;
            hw = r;
            reset = 0;
        } out_raw;
    } ACT_CFG @ 0x90;

    // Tile size (0xA0 / 0xB0) - the grid TILE_CFG indexes: a tile's first
    // canvas row is TILE_CFG.tile_r*TILE_ROWS, its first canvas column
    // TILE_CFG.tile_c*TILE_COLS. Decoupled from this matmul's own size so
    // an edge tile can be smaller (its WEIGHT_ROWS / INPUT_COLS) and still
    // land on the grid; it should not be larger, or it runs into the next
    // tile. 0 = use this matmul's WEIGHT_ROWS / INPUT_COLS (equal-size
    // tiles). tile_r*TILE_ROWS must be a multiple of 16 - simplest is a
    // TILE_ROWS that is one. Latched at matmul_start.
    reg {
        field {
            sw = w;
            hw = r;
            reset = 0;
        } value [15:0];
    } TILE_ROWS @ 0xA0;

    reg {
        field {
            sw = w;
            hw = r;
            reset = 0;
        } value [15:0];
    } TILE_COLS @ 0xB0;
};