addrmap ctrl_rf {
    // Register stride: every register sits at its own 16-byte (128-bit)
    // aligned address, matching accel_top's 128-bit Avalon data bus. A
    // 128-bit master only ever presents word-aligned addresses (byte lanes
    // are picked with byteenable), so registers packed 4 bytes apart could
    // not be addressed individually. Each register's value is in the low
    // bits of its word (byte lanes 0..3). Offsets are pinned with @ below.
    //
    // Control Register (0x00) - single sw-pulsed start bit. The rest of the
    // weight/input control sequencing (weight block prefetch, input preload,
    // compute start) is still TODO - it'll be driven some other way, not
    // more single-pulse CONTROL bits like the ones this replaced.
    reg {
        field {
            singlepulse = true; // Single pulse mode
            reset = 0;
            sw = w;    // Read-write
            hw = r;    // No hardware feedback
        } matmul_start;        // a new matmul is starting: latch WEIGHT_ROWS/
                                // WEIGHT_COLS and reset weight_ctrl's block
                                // position to (0,0)

    } CONTROL @ 0x00;

    // Weight matrix dimensions (0x10/0x20). weight_buffer can hold more than
    // one 32x32 tile's worth of weights; these describe the full extent so
    // future multi-tile loads know how many tiles to prefetch.
    //
    // WEIGHT_ROWS/WEIGHT_COLS name which pe_array axis a dimension loads
    // into, NOT "row/col of the weight matrix as you'd write it on paper":
    //   - WEIGHT_ROWS feeds pe_array's ARRAY_ROWS axis, which pe.v's b_in
    //     cascades down and sums - i.e. WEIGHT_ROWS is the CONTRACTION size.
    //   - WEIGHT_COLS feeds ARRAY_COLS - values here stay separate (one
    //     accumulated result per array column) - i.e. the OUTPUT size.
    // If your weight matrix is conventionally (out_features x in_features),
    // program WEIGHT_ROWS = in_features and WEIGHT_COLS = out_features,
    // regardless of which one is literally "rows" in that convention. See
    // rtl/weight_ctrl.v's header comment for the full reasoning.
    reg {
        field {
            sw = w;
            hw = r;
            reset = 0;
        } value [15:0];   // contraction (reduction) dimension size
    } WEIGHT_ROWS @ 0x10;

    reg {
        field {
            sw = w;
            hw = r;
            reset = 0;
        } value [15:0];   // output dimension size
    } WEIGHT_COLS @ 0x20;

    // Input dimensions (0x30/0x40). No separate row-count register: the
    // valid row range for the block currently in the array is derived by
    // weight_ctrl from WEIGHT_ROWS and the current block position, since
    // weight rows (K) and activation rows share the same array-row extent.
    reg {
        field {
            sw = w;
            hw = r;
            reset = 0;
        } value [9:0];    // max input_buffer read address (input_dispatch i_max_addr)
    } INPUT_MAX_ADDR @ 0x30;

    reg {
        field {
            sw = w;
            hw = r;
            reset = 0;
        } value [15:0];   // number of columns of the input (activation) matrix
    } INPUT_COLS @ 0x40;

    // Status Register (0x50)
    reg {
        field {
            sw = r;
            hw = w;
            reset = 0;
        } busy;               // compute running (weights loading, streaming, or draining)

        field {
            sw = r;
            hw = w;
            rclr = true;
        } done;               // whole matmul finished: all blocks committed and drained

    } STATUS @ 0x50;

    // Output rescale factor (0x60). Q0.16 fixed point: unsigned, 0 integer
    // bits + 16 fractional bits, representable range [0, 1) - value/65536
    // is the actual scale. Meant to rescale pe_array's 32-bit accumulator
    // (see pe.v's ACC_WIDTH) back down to int8 under the quantization
    // scheme this array targets; not yet consumed downstream of
    // output_loader (see rtl/accel_top.sv).
    reg {
        field {
            sw = w;
            hw = r;
            reset = 0;
        } value [15:0];
    } OUTPUT_SCALE @ 0x60;

    // Output tile placement (0x70). The output buffer holds one int8 canvas
    // (width: TILED_MAT_DIM); this matmul's K x M result lands with its top-left corner at
    // canvas row tile_r*WEIGHT_ROWS, column tile_c*INPUT_COLS. Every tile
    // of one result must use the same K and M, and with tile_r > 0, K must
    // be a multiple of 16 (bank boundary). use_prev_out: the first
    // contraction block accumulates onto the canvas instead of overwriting
    // it, to split a long contraction across matmuls. Latched at
    // matmul_start. See rtl/accel_top.sv's TILE_CFG latch.
    reg {
        field {
            sw = w;
            hw = r;
            reset = 0;
        } tile_r [14:0];

        field {
            sw = w;
            hw = r;
            reset = 0;
        } tile_c [29:15];

        field {
            sw = w;
            hw = r;
            reset = 0;
        } use_prev_out;
    } TILE_CFG @ 0x70;

    // Output canvas width (0x80): the whole result's column count when it
    // is built from tiles, so the canvas reads back as one dense row-major
    // matrix (rows padded to a 16-byte word). 0 = use INPUT_COLS, for one
    // untiled matmul. Must stay the same from the first tile until the
    // canvas has been read.
    reg {
        field {
            sw = w;
            hw = r;
            reset = 0;
        } tiled_c_dim[15:0];
    } TILED_MAT_DIM @ 0x80;
};